// Nanopore DC I-V Testbench
// Sebastian Claudiusz Magierowski Nov 23 2025
// DC sweep analysis
simulator lang=spectre
// Include the nanopore netlist
include "../../netlist/nanopore.scs"
// Top-level testbench
parameters vstart=0 vstop=1 vstep=0.01

// Nanopore instance
XP1 (p 0) nanopore

// Voltage source for DC sweep
V1 (p 0) vsource dc=vstart

// DC analysis
dc1 dc dev=V1 param=dc start=vstart stop=vstop step=vstep

// Save outputs
save XP1:p XP1:n
saveOptions options save=selected
